Diode breakdown with source and model series resistance
Vreverse supply 0 10
Rfeed supply cathode 1k
Dbreak 0 cathode dbreak AREA=2
.model dbreak D(IS=1e-12 N=1.1 RS=10 BV=5 IBV=100u NBV=1.5)
.options reltol=1e-6 abstol=1e-14
.op
.print op v(cathode) i(Vreverse)
.end
