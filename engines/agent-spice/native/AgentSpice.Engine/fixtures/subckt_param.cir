Nested parameterized subcircuits
.param base_r={500*sqrt(4)}
+ global_gain={max(1, 3-1)}
.global supply
Vsupply supply 0 1
Vdrive input 0 DC 0.25 AC {global_gain/2} PULSE(0.25 1 1n 0.2n 0.2n 1.5n 3n)
Xamplifier input output wrapper total_gain={global_gain} r={base_r*2}
Rexternal output 0 {base_r*4}
.subckt stage stage_in stage_out params: gain=1 load=1k
Eamp buffer 0 stage_in 0 {gain}
Rseries buffer stage_out {load/2}
Rshunt stage_out 0 {load}
Rglobal stage_out supply {load*4}
.ends stage
.subckt wrapper wrapper_in wrapper_out params: total_gain=1 r=1k
.param child_gain={total_gain+1}
Xinner wrapper_in wrapper_out stage gain={child_gain} load={r}
.ends wrapper
.op
.dc Vdrive 0 1 0.1
.ac dec 2 1k 1meg
.tran 0.2n 4n
.print op v(output)
.print dc v(output)
.print ac v(output)
.print tran v(output)
.end
