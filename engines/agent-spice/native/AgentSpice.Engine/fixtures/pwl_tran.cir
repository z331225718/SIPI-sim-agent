PWL source event scheduling
Vdrive input 0 PWL(0 0.2 1.35n 0.2 1.75n 1 3.15n 0.1 5n 0.5)
Rsource input output 100
Cload output 0 20p
.options reltol=1e-4 vntol=1e-8 abstol=1e-12
.tran 0.2n 6n
.print tran v(input) v(output)
.end
