EXP source with rise and fall events
Vdrive input 0 EXP(0.1 1 1.3n 0.5n 5.2n 0.8n)
Rsource input output 100
Cload output 0 20p
.options reltol=1e-4 vntol=1e-8 abstol=1e-12
.tran 0.2n 10n
.print tran v(input) v(output)
.end
