Level-1 NMOS overlap and junction capacitance Gear2 regression
Vdd supply 0 5
Rload supply out 1k
Vgate gate 0 PULSE(0 3 2n 0.2n 0.2n 4n 10n)
M1 out gate 0 0 nch L=1u W=20u AD=10p AS=8p PD=12u PS=10u
.model nch nmos (level=1 vto=0.7 kp=200u gamma=0.4 phi=0.7 lambda=0.02 is=2e-14 pb=0.8 cbd=1p cbs=0.5p cj=100u mj=0.45 cjsw=100p mjsw=0.35 cgso=100n cgdo=80n cgbo=50n fc=0.5)
.options method=gear
.tran 0.1n 30n
.print tran v(out) i(Vgate)
.end
