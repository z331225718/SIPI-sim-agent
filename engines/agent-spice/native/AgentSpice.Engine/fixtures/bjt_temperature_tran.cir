Temperature-adjusted BJT dynamic transient
.temp 100
.options tnom=27 reltol=1e-4 vntol=1e-8 abstol=1e-12
Vdd supply 0 5
Rload supply out 1k
Vbase base 0 PULSE(0.4 0.7 2n 1n 1n 12n 30n)
Qhot out base 0 nhot AREA=2 M=1.5
.model nhot NPN(IS=1.5e-15 BF=160 BR=3 NF=1.04 NR=1.1 VAF=90 VAR=20 TNOM=25 EG=1.08 XTI=2.7 XTB=0.4 CJE=18p VJE=0.72 MJE=0.36 TF=0.8n CJC=8p VJC=0.68 MJC=0.32 TR=3n FC=0.45)
.tran 0.5n 45n
.print tran v(base) v(out) i(Vbase) i(Vdd)
.end
