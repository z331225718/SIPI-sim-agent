Diode area-scaled series resistance DC sweep
Vdrive drive 0 0
Dseries drive 0 dseries AREA=2 M=3
.model dseries D(IS=1e-12 N=1.1 RS=12)
.options reltol=1e-6 abstol=1e-14
.dc Vdrive 0.1 1.0 0.1
.print dc i(Vdrive)
.end
