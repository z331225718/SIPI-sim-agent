Level-1 PNP operating point
Vee emitter 0 5
Vbase base 0 4.3
Rcollector collector 0 1k
Qswitch collector base emitter transistor_pnp
.model transistor_pnp PNP(IS=1e-15 BF=100 BR=2 NF=1 NR=1)
.options reltol=1e-8 vntol=1e-10 abstol=1e-14
.op
.print op v(collector) i(Vbase)
.end
