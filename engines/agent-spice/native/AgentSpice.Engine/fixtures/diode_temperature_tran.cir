Temperature-adjusted diode transient charge
.temp 100
.options tnom=27 reltol=1e-4 vntol=1e-8 abstol=1e-12
Vdrive in 0 PULSE(0.1 0.85 2n 1n 1n 12n 30n)
Rsource in out 100
Dhot out 0 dhot AREA=2 M=1.5
.model dhot D(IS=1.5e-12 N=1.15 TNOM=25 EG=1.08 XTI=2.7 CJO=18p VJ=0.72 M=0.42 TT=1.5n FC=0.45)
.tran 0.5n 45n
.print tran v(in) v(out) i(Vdrive)
.end
