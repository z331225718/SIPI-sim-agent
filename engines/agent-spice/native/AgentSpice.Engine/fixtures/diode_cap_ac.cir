Dynamic diode small-signal capacitance
Vdrive in 0 0.5 AC 1
Rsource in out 100
Dload out 0 diode_dynamic
.model diode_dynamic D(IS=1e-12 N=1 CJO=20p VJ=0.7 M=0.4 TT=2n FC=0.5)
.options reltol=1e-8 vntol=1e-10 abstol=1e-14
.ac lin 1 100meg 100meg
.print ac real(v(out)) imag(v(out))
.end
