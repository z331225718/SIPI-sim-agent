Level-1 NMOS oxide and Meyer intrinsic capacitance transient regression
Vdd supply 0 5
Rload supply out 5k
Vgate gate 0 PULSE(0 3 2n 0.2n 0.2n 4n 10n)
M1 out gate 0 0 nch L=1u W=100u
Cload out 0 0.5p
.model nch nmos (level=1 vto=0.7 uo=650 tox=20n gamma=0.4 phi=0.7 lambda=0.02 cgso=20n cgdo=15n cgbo=10n)
.tran 0.05n 30n
.print tran v(out) i(Vgate) i(Vdd)
.end
