Diode Newton DC sweep
Vdrive in 0 0
Rsource in out 1k
Dclamp out 0 diode_default
.model diode_default D(IS=1e-12 N=1)
.options reltol=1e-8 vabstol=1e-10 iabstol=1e-14
.dc Vdrive 0 1 0.1
.print dc v(out)
.end
