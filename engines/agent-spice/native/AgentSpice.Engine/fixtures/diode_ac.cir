Diode Newton AC small signal
Vdrive in 0 dc 1 ac 1
Rsource in out 1k
Dclamp out 0 diode_default
.model diode_default D(IS=1e-12 N=1)
.ac lin 1 1k 1k
.print ac real(v(out)) imag(v(out))
.end
