Level-1 complementary MOS inverter DC regression
Vdd supply 0 5
Vin input 0 0
Mpullup out input supply supply pch L=1u W=40u
Mpulldown out input 0 0 nch L=1u W=20u
.model nch nmos (level=1 vto=0.7 kp=200u gamma=0.4 phi=0.7 lambda=0.02)
.model pch pmos (level=1 vto=-0.75 kp=100u gamma=0.35 phi=0.65 lambda=0.025)
.options reltol=1e-8 vntol=1e-10 abstol=1e-14
.dc Vin 0 5 0.25
.print dc v(out) i(Vdd)
.end
