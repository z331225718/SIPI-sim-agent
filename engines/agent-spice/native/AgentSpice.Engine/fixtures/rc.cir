Agent-Spice native RC smoke
V1 in 0 PULSE(0 1 1u 1n 1n 10u 20u) AC 1
R1 in out 1k
C1 out 0 1u
.op
.ac lin 3 1 3
.tran 1u 3u
.end
