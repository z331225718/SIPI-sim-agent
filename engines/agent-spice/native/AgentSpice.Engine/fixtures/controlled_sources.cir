Linear dependent sources
Vdrive input 0 DC 0.25 AC 1 PULSE(0.25 1 1n 0.2n 0.2n 1.5n 3n)
Rdrive input sense 1k
Vsense sense 0 0
Evcvs eout 0 input 0 3
Reload eout 0 1k
Gvccs gout 0 input 0 2m
Rgload gout 0 1k
Fcccs fout 0 Vsense 2
Rfload fout 0 1k
Hccvs hout 0 Vsense 500
Rhload hout 0 1k
.op
.dc Vdrive 0 1 0.25
.ac lin 3 1k 1meg
.tran 0.2n 4n
.print op v(eout) v(gout) v(fout) v(hout) i(Evcvs) i(Hccvs)
.print dc v(eout) v(gout) v(fout) v(hout)
.print ac v(eout) v(gout) v(fout) v(hout)
.print tran v(eout) v(gout) v(fout) v(hout)
.end
