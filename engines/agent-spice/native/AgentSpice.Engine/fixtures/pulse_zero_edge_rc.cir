Zero PULSE rise and fall use transient output step
Vdrive in 0 PULSE(0 1 2n 0 0 4n 10n)
Rsource in out 100
Cload out 0 20p
.options reltol=1e-4 vntol=1e-8 abstol=1e-12
.tran 1n 10n
.print tran v(in) v(out)
.end
