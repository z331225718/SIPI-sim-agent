Level-1 NPN dynamic small signal
Vcc vcc 0 5
Vbase base 0 dc 0.68 ac 1m
Rcollector vcc collector 1k
Qdevice collector base 0 transistor_npn
.model transistor_npn NPN(IS=1e-15 BF=120 BR=3 NF=1 NR=1 VAF=80 VAR=25 CJE=8p VJE=0.75 MJE=0.33 TF=0.4n CJC=3p VJC=0.75 MJC=0.33 TR=20n FC=0.5)
.options reltol=1e-8 vntol=1e-10 abstol=1e-14
.ac dec 5 1k 1g
.print ac real(v(collector)) imag(v(collector)) real(i(Vbase)) imag(i(Vbase))
.end
