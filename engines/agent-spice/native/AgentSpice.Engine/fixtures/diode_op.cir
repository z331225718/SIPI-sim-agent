Diode Newton operating point
Vdrive in 0 1
Rsource in out 1k
Dclamp out 0 diode_default
.model diode_default D(IS=1e-12 N=1)
.op
.print op v(out)
.end
