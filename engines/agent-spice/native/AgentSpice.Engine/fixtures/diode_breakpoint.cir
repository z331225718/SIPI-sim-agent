Dynamic diode coarse output with pulse breakpoints
Vdrive in 0 PULSE(0 1 2n 1n 1n 12n 30n)
Rsource in out 100
Dclamp out 0 diode_dynamic
.model diode_dynamic D(IS=1e-12 N=1 CJO=20p VJ=0.7 M=0.4 TT=2n FC=0.5)
.options reltol=1e-4 vntol=1e-8 abstol=1e-12
.tran 5n 20n
.print tran v(in) v(out)
.end
