Level-1 NMOS oxide and Meyer intrinsic capacitance AC regression
Vdd supply 0 5
Rload supply out 10k
Vgate gate 0 1.5 ac 1
M1 out gate 0 0 nch L=1u W=100u
.model nch nmos (level=1 vto=0.7 uo=650 tox=20n gamma=0.4 phi=0.7 lambda=0.02 cgso=20n cgdo=15n cgbo=10n)
.ac dec 5 1k 100g
.print ac v(out) i(Vgate)
.end
