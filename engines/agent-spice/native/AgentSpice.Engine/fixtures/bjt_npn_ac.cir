Level-1 NPN AC small signal
Vcc vcc 0 5
Vbase base 0 dc 0.7 ac 1m
Rcollector vcc collector 1k
Qswitch collector base 0 transistor_npn
.model transistor_npn NPN(IS=1e-15 BF=100 BR=2 NF=1 NR=1)
.options reltol=1e-8 vntol=1e-10 abstol=1e-14
.ac lin 1 1k 1k
.print ac real(v(collector)) imag(v(collector)) real(i(Vbase)) imag(i(Vbase))
.end
